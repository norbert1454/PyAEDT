# Ansys Electronics Desktop project, version 2024.2
project variables:
  $ferrite_epsilon = 20
  $ferrite_tand = 0.005
  $ferrite_Mr = 3500gauss
  $ferrite_delta_H = 200Oe
  $ferrite_freq_delta_H = 40GHz
  $ferrite_mu_effective = 1.2804107
materials:
  vacuum: permittivity=1
  mon_ferrite_taper: permittivity=$ferrite_epsilon permeability=$ferrite_mu_effective dielectric_loss_tangent=$ferrite_tand
  mon_ferrite: permittivity=$ferrite_epsilon permeability=1 dielectric_loss_tangent=$ferrite_tand
  gold: permeability=0.99996 conductivity=41000000
  pec: conductivity=1e+30
surface materials:
  Steel-oxidised-surface

design Circulateur (HFSS, HFSS Modal Network, model units mm)
options: open_region{BoundaryType=0 OpFreq=18GHz}
variables:
  hauteur_substrat = 100um
  longueur_substrat_arriere = 2000um
  longueur_substrat_avant = 2000um
  longueur_substrat = longueur_substrat_avant + longueur_substrat_arriere
  largeur_substrat = 4000um
  largeur_taper = 100um
  rayon_jonction = 950um
  longueur_adaptation = 600um
  longueur_adaptation_1 = longueur_adaptation
  longueur_adaptation_2 = longueur_adaptation
  longueur_adaptation_3 = longueur_adaptation
  largeur_adaptation = 48um
  largeur_adaptation_1 = largeur_adaptation
  largeur_adaptation_2 = largeur_adaptation
  largeur_adaptation_3 = largeur_adaptation
  epaisseur_metallisation = 4um
  largeur_50_Ohm = 48um
  emplacement_ports = -0.9mm
  rayon_courbure = 500um
  rayon_courbure_2 = rayon_courbure
  rayon_courbure_3 = rayon_courbure
  longueur_50_Ohm_avant_courbe_2 = (-emplacement_ports-(rayon_jonction+longueur_adaptation_2)*sin(30deg)-rayon_courbure_2*(1-cos(30deg)))/sin(30deg)
  longueur_50_Ohm_avant_courbe_3 = (-emplacement_ports-(rayon_jonction+longueur_adaptation_3)*sin(30deg)-rayon_courbure_3*(1-cos(30deg)))/sin(30deg)
  longueur_50_Ohm_2 = largeur_substrat/2-(rayon_jonction+longueur_adaptation_2+longueur_50_Ohm_avant_courbe_2)*cos(30deg)-rayon_courbure_2*sin(30deg)
  longueur_50_Ohm_3 = largeur_substrat/2-(rayon_jonction+longueur_adaptation_3+longueur_50_Ohm_avant_courbe_3)*cos(30deg)-rayon_courbure_3*sin(30deg)
  hauteur_port = 200um
  largeur_port = 960um
  epaisseur_pec = 10um
  rayon_ferrite = 950um
  hauteur_ferrite = 100um
  Hk = 18000
  Mr = 3500
  N1 = (largeur_substrat^2 - hauteur_substrat^2)/(2*largeur_substrat*hauteur_substrat)*ln((sqrt(longueur_substrat^2 + largeur_substrat^2 + hauteur_substrat^2) - longueur_substrat)/(sqrt(longueur_substrat^2 + largeur_substrat^2 + hauteur_substrat^2) + longueur_substrat))
  N2 = (longueur_substrat^2 - hauteur_substrat^2)/(2*longueur_substrat*hauteur_substrat)*ln((sqrt(longueur_substrat^2 + largeur_substrat^2 + hauteur_substrat^2) - largeur_substrat)/(sqrt(longueur_substrat^2 + largeur_substrat^2 + hauteur_substrat^2) + largeur_substrat))
  N3 = largeur_substrat/(2*hauteur_substrat)*ln((sqrt(longueur_substrat^2 + largeur_substrat^2) + longueur_substrat)/(sqrt(longueur_substrat^2 + largeur_substrat^2) - longueur_substrat))
  N4 = longueur_substrat/(2*hauteur_substrat)*ln((sqrt(longueur_substrat^2 + largeur_substrat^2) + largeur_substrat)/(sqrt(longueur_substrat^2 + largeur_substrat^2) - largeur_substrat))
  N5 = hauteur_substrat/(2*longueur_substrat)*ln((sqrt(largeur_substrat^2 + hauteur_substrat^2) - largeur_substrat)/(sqrt(largeur_substrat^2 + hauteur_substrat^2) + largeur_substrat))
  N6 = hauteur_substrat/(2*largeur_substrat)*ln((sqrt(longueur_substrat^2 + hauteur_substrat^2) - longueur_substrat)/(sqrt(longueur_substrat^2 + hauteur_substrat^2) + longueur_substrat))
  N7 = 2*atan((longueur_substrat*largeur_substrat)/(hauteur_substrat*sqrt(longueur_substrat^2+largeur_substrat^2+hauteur_substrat^2)))
  N8 = (longueur_substrat^3+largeur_substrat^3-2*hauteur_substrat^3)/(3*longueur_substrat*largeur_substrat*hauteur_substrat)
  N9 = (longueur_substrat^2+largeur_substrat^2-2*hauteur_substrat^2)/(3*longueur_substrat*largeur_substrat*hauteur_substrat)*sqrt(longueur_substrat^2+largeur_substrat^2+hauteur_substrat^2)
  N10 = hauteur_substrat/(longueur_substrat*largeur_substrat)*(sqrt(longueur_substrat^2+hauteur_substrat^2)+sqrt(largeur_substrat^2+hauteur_substrat^2))
  N11 = ((longueur_substrat^2+largeur_substrat^2)^(3/2)+(largeur_substrat^2+hauteur_substrat^2)^(3/2)+(hauteur_substrat^2+longueur_substrat^2)^(3/2))/(3*longueur_substrat*largeur_substrat*hauteur_substrat)
  Nz = (N1+N2+N3+N4+N5+N6+N7+N8+N9+N10-N11)/pi
  Hint = Hk-Nz*Mr
  Hint_apm = 1000*Hint/(4*pi)
geometry:
  GND [gold] = box(corner=(-longueur_substrat_arriere, -largeur_substrat/2, 0mm), size=(longueur_substrat, largeur_substrat, -epaisseur_metallisation))
  Ferrite [mon_ferrite] = box(corner=(-longueur_substrat_arriere+largeur_taper, -largeur_substrat/2+largeur_taper, 0mm), size=(longueur_substrat-2*largeur_taper, largeur_substrat-2*largeur_taper, hauteur_substrat))
  Taper [mon_ferrite_taper] = box(corner=(-longueur_substrat_arriere, -largeur_substrat/2, 0mm), size=(longueur_substrat, largeur_substrat, hauteur_substrat))
  Ferrite_1 = Ferrite.copy()
  Taper.subtract(Ferrite_1)
  Jonction [gold] = cylinder(axis=Z, base_centre=(0mm, 0mm, hauteur_substrat), radius=rayon_jonction, height=epaisseur_metallisation)
  Ligne_adaptation_1 = box(corner=(0mm, -largeur_adaptation_1/2, hauteur_substrat), size=(rayon_jonction+longueur_adaptation_1, largeur_adaptation_1, epaisseur_metallisation))
  Ligne_adaptation_2 = box(corner=(0mm, -largeur_adaptation_2/2, hauteur_substrat), size=(rayon_jonction+longueur_adaptation_2, largeur_adaptation_2, epaisseur_metallisation))
  Ligne_adaptation_2.rotate(axis=Z, angle=120deg)
  Ligne_adaptation_3 = box(corner=(0mm, -largeur_adaptation_3/2, hauteur_substrat), size=(rayon_jonction+longueur_adaptation_3, largeur_adaptation_3, epaisseur_metallisation))
  Ligne_adaptation_3.rotate(axis=Z, angle=240deg)
  Ligne_50_Ohm_1 = box(corner=(rayon_jonction+longueur_adaptation_1, -largeur_50_Ohm/2, hauteur_substrat), size=(longueur_substrat_avant-rayon_jonction-longueur_adaptation_1, largeur_50_Ohm, epaisseur_metallisation))
  Ligne_50_Ohm_avant_courbe_2 = box(corner=(rayon_jonction+longueur_adaptation_2, -largeur_50_Ohm/2, hauteur_substrat), size=(longueur_50_Ohm_avant_courbe_2, largeur_50_Ohm, epaisseur_metallisation))
  Ligne_50_Ohm_avant_courbe_2.rotate(axis=Z, angle=120deg)
  Ligne_50_Ohm_avant_courbe_3 = box(corner=(rayon_jonction+longueur_adaptation_3, -largeur_50_Ohm/2, hauteur_substrat), size=(longueur_50_Ohm_avant_courbe_3, largeur_50_Ohm, epaisseur_metallisation))
  Ligne_50_Ohm_avant_courbe_3.rotate(axis=Z, angle=240deg)
  Ligne_50_Ohm_Courbe_2 = equation_based_surface(XuvFunction=_u*cos(_v)-sin(30deg)*(rayon_jonction+longueur_adaptation_2+longueur_50_Ohm_avant_courbe_2)+cos(30deg)*rayon_courbure_2 YuvFunction=_u*sin(_v)+cos(30deg)*(rayon_jonction+longueur_adaptation_2+longueur_50_Ohm_avant_courbe_2)+sin(30deg)*rayon_courbure_2 ZuvFunction=hauteur_substrat uStart=rayon_courbure_2-largeur_50_Ohm/2 uEnd=rayon_courbure_2+largeur_50_Ohm/2 vStart=180deg vEnd=210deg)
  Ligne_50_Ohm_Courbe_2.thicken(epaisseur_metallisation)
  Ligne_50_Ohm_Courbe_3 = equation_based_surface(XuvFunction=_u*cos(_v)-sin(30deg)*(rayon_jonction+longueur_adaptation_3+longueur_50_Ohm_avant_courbe_3)+cos(30deg)*rayon_courbure_3 YuvFunction=_u*sin(_v)-cos(30deg)*(rayon_jonction+longueur_adaptation_3+longueur_50_Ohm_avant_courbe_3)-sin(30deg)*rayon_courbure_3 ZuvFunction=hauteur_substrat uStart=rayon_courbure_3-largeur_50_Ohm/2 uEnd=rayon_courbure_3+largeur_50_Ohm/2 vStart=150deg vEnd=180deg)
  Ligne_50_Ohm_Courbe_3.thicken(epaisseur_metallisation)
  Ligne_50_Ohm_2 = box(corner=(emplacement_ports-largeur_50_Ohm/2, largeur_substrat/2, hauteur_substrat), size=(largeur_50_Ohm, -longueur_50_Ohm_2, epaisseur_metallisation))
  Ligne_50_Ohm_3 = box(corner=(emplacement_ports-largeur_50_Ohm/2, -largeur_substrat/2, hauteur_substrat), size=(largeur_50_Ohm, longueur_50_Ohm_3, epaisseur_metallisation))
  Jonction.unite(Ligne_adaptation_1, Ligne_50_Ohm_1, Ligne_adaptation_2, Ligne_50_Ohm_avant_courbe_2, Ligne_50_Ohm_Courbe_2, Ligne_50_Ohm_2, Ligne_adaptation_3, Ligne_50_Ohm_avant_courbe_3, Ligne_50_Ohm_Courbe_3, Ligne_50_Ohm_3)
  PEC_Port_1 [pec] = box(corner=(longueur_substrat_avant, -largeur_port/2, 0mm), size=(epaisseur_pec, largeur_port, hauteur_port))
  PEC_Port_2 [pec] = box(corner=(emplacement_ports-largeur_port/2, largeur_substrat/2, 0mm), size=(largeur_port, epaisseur_pec, hauteur_port))
  PEC_Port_3 [pec] = box(corner=(emplacement_ports-largeur_port/2, -largeur_substrat/2, 0mm), size=(largeur_port, -epaisseur_pec, hauteur_port))
  RadiatingSurface [vacuum] = region(absolute_offset=5.5555556mm on all sides)
boundaries and excitations:
  AutoOpen1: Radiation Objects=RadiatingSurface
  1: Wave Port Faces=PEC_Port_1.face(-x) WavePortType=Modal NumModes=1 Modes{Mode1{CharImp=Zpi RenormImp=50ohm}}
  2: Wave Port Faces=PEC_Port_2.face(-y) WavePortType=Modal NumModes=1 Modes{Mode1{CharImp=Zpi RenormImp=50ohm}}
  3: Wave Port Faces=PEC_Port_3.face(+y) WavePortType=Modal NumModes=1 Modes{Mode1{CharImp=Zpi RenormImp=50ohm}}
setups:
  Setup: HfssDriven Frequency=18GHz MaxDeltaS=0.02 MaximumPasses=30 MinimumPasses=1 MinimumConvergedPasses=1 PercentRefinement=20 BasisOrder=1 PortAccuracy=2 DrivenSolverType="Direct Solver"
    sweep Sweep: 16GHz to 20GHz step 0.05GHz; Type=Interpolating SaveFields InterpTolerance=0.5 InterpMaxSolns=250 InterpUsePortImped=false PassivityErrorTolerance=0.0001
source amplitudes:
  1:1: 1W 0deg
  2:1, 3:1: 0W 0deg
radiation setups:
  3D: Infinite Sphere Theta=0deg..180deg step 2deg Phi=-180deg..180deg step 2deg
  Elevation: Infinite Sphere Theta=-180deg..180deg step 1deg Phi=0deg..90deg step 90deg
  Azimuth: Infinite Sphere Theta=90deg..90deg step 0deg Phi=-180deg..180deg step 1deg
reports:
  Tous les ports: dB(S(1,1)), dB(S(2,1)), dB(S(3,1)), dB(S(2,2)), dB(S(3,2)), dB(S(1,2)), dB(S(3,3)), dB(S(1,3)), dB(S(2,3)) vs Freq on Setup : Sweep [hauteur_substrat=100um longueur_substrat_arriere=2000um longueur_substrat_avant=2000um largeur_substrat=4000um largeur_taper=100um rayon_jonction=950um longueur_adaptation=600um largeur_adaptation=48um epaisseur_metallisation=4um largeur_50_Ohm=48um emplacement_ports=-0.9mm rayon_courbure=500um hauteur_port=200um largeur_port=960um epaisseur_pec=10um rayon_ferrite=950um hauteur_ferrite=100um Hk=18000 Mr=3500 $ferrite_epsilon=20 $ferrite_tand=0.005 $ferrite_Mr=0.35 $ferrite_delta_H=15915.5 $ferrite_freq_delta_H=40GHz $ferrite_mu_effective=1.28041]
  Port 1: db(S11), db(S21), db(S31) vs Freq on Setup : Sweep [hauteur_substrat=100um longueur_substrat_arriere=2000um longueur_substrat_avant=2000um largeur_substrat=4000um largeur_taper=100um rayon_jonction=950um longueur_adaptation=600um largeur_adaptation=48um epaisseur_metallisation=4um largeur_50_Ohm=48um emplacement_ports=-0.9mm rayon_courbure=500um hauteur_port=200um largeur_port=960um epaisseur_pec=10um rayon_ferrite=950um hauteur_ferrite=100um Hk=18000 Mr=3500 $ferrite_epsilon=20 $ferrite_tand=0.005 $ferrite_Mr=0.35 $ferrite_delta_H=15915.5 $ferrite_freq_delta_H=40GHz $ferrite_mu_effective=1.28041]
  Port 2: dB(S(2,2)), dB(S(3,2)), dB(S(1,2)) vs Freq on Setup : Sweep [hauteur_substrat=100um longueur_substrat_arriere=2000um longueur_substrat_avant=2000um largeur_substrat=4000um largeur_taper=100um rayon_jonction=950um longueur_adaptation=600um largeur_adaptation=48um epaisseur_metallisation=4um largeur_50_Ohm=48um emplacement_ports=-0.9mm rayon_courbure=500um hauteur_port=200um largeur_port=960um epaisseur_pec=10um rayon_ferrite=950um hauteur_ferrite=100um Hk=18000 Mr=3500 $ferrite_epsilon=20 $ferrite_tand=0.005 $ferrite_Mr=0.35 $ferrite_delta_H=15915.5 $ferrite_freq_delta_H=40GHz $ferrite_mu_effective=1.28041]
  Port 3: dB(S(3,3)), dB(S(1,3)), dB(S(2,3)) vs Freq on Setup : Sweep [hauteur_substrat=100um longueur_substrat_arriere=2000um longueur_substrat_avant=2000um largeur_substrat=4000um largeur_taper=100um rayon_jonction=950um longueur_adaptation=600um largeur_adaptation=48um epaisseur_metallisation=4um largeur_50_Ohm=48um emplacement_ports=-0.9mm rayon_courbure=500um hauteur_port=200um largeur_port=960um epaisseur_pec=10um rayon_ferrite=950um hauteur_ferrite=100um Hk=18000 Mr=3500 $ferrite_epsilon=20 $ferrite_tand=0.005 $ferrite_Mr=0.35 $ferrite_delta_H=15915.5 $ferrite_freq_delta_H=40GHz $ferrite_mu_effective=1.28041]
  Adaptation: dB(S(1,1)), dB(S(2,2)), dB(S(3,3)) vs Freq on Setup : Sweep [hauteur_substrat=100um longueur_substrat_arriere=2000um longueur_substrat_avant=2000um largeur_substrat=4000um largeur_taper=100um rayon_jonction=950um longueur_adaptation=600um largeur_adaptation=48um epaisseur_metallisation=4um largeur_50_Ohm=48um emplacement_ports=-0.9mm rayon_courbure=500um hauteur_port=200um largeur_port=960um epaisseur_pec=10um rayon_ferrite=950um hauteur_ferrite=100um Hk=18000 Mr=3500 $ferrite_epsilon=20 $ferrite_tand=0.005 $ferrite_Mr=0.35 $ferrite_delta_H=15915.5 $ferrite_freq_delta_H=40GHz $ferrite_mu_effective=1.28041]
  Isolation: dB(S(2,1)), dB(S(3,2)), dB(S(1,3)) vs Freq on Setup : Sweep [hauteur_substrat=100um longueur_substrat_arriere=2000um longueur_substrat_avant=2000um largeur_substrat=4000um largeur_taper=100um rayon_jonction=950um longueur_adaptation=600um largeur_adaptation=48um epaisseur_metallisation=4um largeur_50_Ohm=48um emplacement_ports=-0.9mm rayon_courbure=500um hauteur_port=200um largeur_port=960um epaisseur_pec=10um rayon_ferrite=950um hauteur_ferrite=100um Hk=18000 Mr=3500 $ferrite_epsilon=20 $ferrite_tand=0.005 $ferrite_Mr=0.35 $ferrite_delta_H=15915.5 $ferrite_freq_delta_H=40GHz $ferrite_mu_effective=1.28041]
  Transmission: dB(S(3,1)), dB(S(1,2)), dB(S(2,3)) vs Freq on Setup : Sweep [hauteur_substrat=100um longueur_substrat_arriere=2000um longueur_substrat_avant=2000um largeur_substrat=4000um largeur_taper=100um rayon_jonction=950um longueur_adaptation=600um largeur_adaptation=48um epaisseur_metallisation=4um largeur_50_Ohm=48um emplacement_ports=-0.9mm rayon_courbure=500um hauteur_port=200um largeur_port=960um epaisseur_pec=10um rayon_ferrite=950um hauteur_ferrite=100um Hk=18000 Mr=3500 $ferrite_epsilon=20 $ferrite_tand=0.005 $ferrite_Mr=0.35 $ferrite_delta_H=15915.5 $ferrite_freq_delta_H=40GHz $ferrite_mu_effective=1.28041]
